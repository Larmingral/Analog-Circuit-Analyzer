Vdd Vdd 0 V dc={Vdd} value=0
Vin in 0 V value={Vin}

Rd Vdd out R value={Rd}
Rs net1 0 R value={Rs}

M1 out in net1 0 M gm={gm1} cgs={cgs1} cdg={cdg1}

.source Vin
.detector V_out
.param Rd=1 Rs=1 Vdd=1 Vin=1 cdg1=1 cgs1=1 gm1=1
.end
