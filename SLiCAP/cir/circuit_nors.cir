Vdd Vdd 0 V value=0 dc={Vdd}
Vin in 0 V value={Vin}

M1 out in 0 0 M gm={gm} cdg={cdg} cgs={cgs}
Rd Vdd out R value={Rd}

.source Vin
.detector V_out
.end
