* --- Common Emitter Amplifier (SLiCAP - Verified Netlist) ---

.title Common Emitter Amplifier

* --- Parameter Definitions ---
.param VCC_val = 12
.param R1_val  = 100e3
.param R2_val  = 22e3
.param RC_val  = 4.7e3
.param RE_val  = 1e3
.param C1_val  = 10e-6
.param C2_val  = 10e-6
.param CE_val  = 100e-6
.param VIN_offset = 0
.param VIN_amp    = 10e-3
.param VIN_freq   = 1e3

* --- Circuit Topology ---
VCC VCC 0 V dc={VCC_val}
R1 VCC VB {R1_val}
R2 VB 0 {R2_val}
RC VCC VC {RC_val}
RE VE 0 {RE_val}
C1 IN VB {C1_val}
C2 VC OUT {C2_val}
CE VE 0 {CE_val}
VIN IN 0 V func=sin args=[{VIN_offset}, {VIN_amp}, {VIN_freq}]

* --- Active Device and Model ---
Q1 VC VB VE 0 NPN_2N2222
.model NPN_2N2222 NPN IS=1e-14 VAF=100 BF=200 IKF=0.3 XTB=1.5 BR=3 CJC=8e-12 CJE=25e-12 TR=100e-9 TF=400e-12

* --- Analysis Directives ---
.source VIN
.detector V(OUT)

.end
